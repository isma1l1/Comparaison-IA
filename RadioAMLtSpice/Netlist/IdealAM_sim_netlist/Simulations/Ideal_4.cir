* AM Radio Receiver - Corrected for Diode Threshold
* -----------------------------------------------------------
* POWER SUPPLY
V1 VCC 0 9V

* ANTENNA & AM SOURCE (Tuned to BBC 5 Live: 693 kHz, 1 kHz Tone)
B_ANT ANT 0 V=0.05 * (1 + 0.8*sin(2*pi*1k*time)) * sin(2*pi*693k*time)
R_ANT ANT TANK_IN 50

* LC TUNING STAGE (693 kHz)
L_TUNE TANK_IN 0 200u
C_TUNE TANK_IN 0 264p

* RF AMPLIFIER (NPN)
C_RF_IN TANK_IN RF_B 10n
Q_RF RF_C RF_B RF_E NPN_IDEAL
R_RF_B VCC RF_B 1Meg
R_RF_C VCC RF_C 4.7k
R_RF_E RF_E 0 1k
C_RF_BYPASS RF_E 0 100n   ; <--- MODIFICATION 1: Emitter Bypass

C_RF_OUT RF_C DET_IN 10n

* ENVELOPE DETECTOR (Demodulator)
D_DET DET_IN DET_OUT 1N34A ; <--- MODIFICATION 2: Germanium Diode
R_DET DET_OUT 0 10k
C_DET DET_OUT 0 10n

* AUDIO AMPLIFIER (NPN)
C_AUD_IN DET_OUT AUD_B 10u
Q_AUD AUD_C AUD_B AUD_E NPN_IDEAL
R_AUD_B VCC AUD_B 1Meg
R_AUD_C VCC AUD_C 4.7k
R_AUD_E AUD_E 0 1k
C_AUD_OUT AUD_C OUT 10u

* LOAD (Headphones)
R_LOAD OUT 0 32

* MODELS
.model NPN_IDEAL NPN(Bf=100)
.model 1N34A D(Is=200n Rs=2 N=1.2 Cjo=1p Eg=0.67) ; <--- MODIFICATION 2: Germanium Parameters

* SIMULATION COMMAND
.tran 0 5m 0 0.1u
.end
