* Ideal AM Radio Receiver - Proof of Concept
* -----------------------------------------------------------
* POWER SUPPLY
V1 VCC 0 9V

* ANTENNA & AM SOURCE (Tuned to BBC 5 Live: 693 kHz, 1 kHz Tone)
* We use an arbitrary behavioral source to generate the AM signal
B_ANT ANT 0 V=0.05 * (1 + 0.8*sin(2*pi*1k*time)) * sin(2*pi*693k*time)
R_ANT ANT TANK_IN 50

* LC TUNING STAGE
* For 693 kHz: L = 200uH, C = 264pF (Added as requested)
L_TUNE TANK_IN 0 200u
C_TUNE TANK_IN 0 264p

* RF AMPLIFIER (NPN)
C_RF_IN TANK_IN RF_B 10n
Q_RF RF_C RF_B RF_E NPN_IDEAL
R_RF_B VCC RF_B 1Meg
R_RF_C VCC RF_C 4.7k
R_RF_E RF_E 0 1k
C_RF_OUT RF_C DET_IN 10n

* ENVELOPE DETECTOR (Demodulator)
D_DET DET_IN DET_OUT D_IDEAL
R_DET DET_OUT 0 10k
C_DET DET_OUT 0 10n

* AUDIO AMPLIFIER (NPN)
C_AUD_IN DET_OUT AUD_B 10u
Q_AUD AUD_C AUD_B AUD_E NPN_IDEAL
R_AUD_B VCC AUD_B 1Meg
R_AUD_C VCC AUD_C 4.7k
R_AUD_E AUD_E 0 1k
C_AUD_OUT AUD_C OUT 10u

* LOAD (Headphones)
R_LOAD OUT 0 32

* IDEAL COMPONENT MODELS
.model NPN_IDEAL NPN(Bf=100)
.model D_IDEAL D(Is=1e-14 N=1 Rs=0 Cjo=0)

* SIMULATION COMMAND (Run for 5 milliseconds to see 5 audio cycles)
.tran 0 5m 0 0.1u
.end
