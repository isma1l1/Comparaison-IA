* IDEAL AUDIO AMPLIFIER

VIN IN 0 AC 1

E1 OUT 0 IN 0 10

RLOAD OUT 0 32

.ac dec 100 10 20k
.end
