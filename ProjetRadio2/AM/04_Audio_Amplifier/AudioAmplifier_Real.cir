* REAL AUDIO AMPLIFIER

VIN IN 0 AC 1

XU1 IN 0 OUT LM386

RLOAD OUT 0 32
VCC VCC 0 DC 9

.ac dec 100 10 20k
.end
