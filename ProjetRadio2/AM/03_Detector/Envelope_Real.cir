* REAL ENVELOPE DETECTOR

D1 IN N1 1N4148
C1 N1 0 1u
R1 N1 OUT 10k

.ac dec 100 100k 2Meg
.end
