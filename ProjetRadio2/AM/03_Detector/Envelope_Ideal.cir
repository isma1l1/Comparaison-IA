* IDEAL ENVELOPE DETECTOR

D1 IN N1 DIDEAL
C1 N1 0 1u
R1 N1 OUT 10k

.model DIDEAL D (IS=1e-12 N=1)
.ac dec 100 100k 2Meg
.end
