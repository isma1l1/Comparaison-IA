* ANTENNA REAL - MODULE

VIN IN 0 AC 1

RANT IN N1 1k
L1 N1 N2 300u
RCOIL N2 N3 30
C1 N3 0 150p
RLOSS N3 0 50k

* OUTPUT = N3

.ac dec 100 100k 2Meg
.end
